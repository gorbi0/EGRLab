P01 R2 gate screening - XML extracted
.options reltol=0.001 abstol=1e-9 vntol=1e-6 method=gear gmin=1e-10
.model pm VDMOS(pchan vto=-1 kp=10 lambda=0.01 rd=0.004 rs=0.004 cgs=1p cgdmax=1p cgdmin=1p cjo=1p)
.model npm NPN(is=1e-14 bf=50 vaf=100 cje=30p cjc=10p tf=2n tr=1e-06)
.model ppm PNP(is=1e-14 bf=50 vaf=100 cje=30p cjc=10p tf=2n tr=1e-06)
.model body D(is=1n n=1.5 rs=0.01)
.model z15 D(is=1n n=1.5 bv=15 ibv=5m rs=10)
Vinput input 0 PWL(0 0 10u 0 11u 24)
Rsource input p01_vs 0.05
Cin p01_vs 0 10u
Venable p01_enable 0 0
Cload vprot 0 0.00022
Rload vprot 0 1000000.0
Bload vprot 0 I=0*tanh(v(vprot)/0.2)
R17 p01_enable p01_on_base 4700
R18 p01_on_base 0 47000
R19 p01_enable p01_release_base 4700
R20 p01_release_base 0 47000
R21 p01_gate p01_on_col 4700
R22 p01_gate p01_vs 100000
R23 p01_off_base 0 2200
R24 p01_off_base p01_vs 100000
R25 p01_release_pbase p01_vs 47000
R26 p01_release_pbase p01_release_col 10000
R27 p01_off_col p01_gate 47
C5 p01_gate vprot 2.2e-07
C6 p01_gate p01_vs 4.7e-08
MQ1 Q1d p01_gate p01_vs pm
VQ1i Q1d vprot 0
DQ1body vprot p01_vs body
CQ1gs p01_gate p01_vs 3.21e-09
CQ1gd p01_gate vprot 2.9e-10
CQ1ds vprot p01_vs 600p
Q2 p01_off_col p01_off_base p01_vs ppm
Q3 p01_on_col p01_on_base 0 npm
Q4 p01_off_base p01_release_pbase p01_vs ppm
Q5 p01_release_col p01_release_base 0 npm
D4 p01_gate p01_vs z15
.tran 5e-08 0.0002 0 5e-08
.end
