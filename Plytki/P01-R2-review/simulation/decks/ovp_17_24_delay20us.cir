P01 R2 gate screening - XML extracted
.options reltol=0.001 abstol=1e-9 vntol=1e-6 method=gear gmin=1e-10
.model pm VDMOS(pchan vto=-3 kp=10 lambda=0.01 rd=0.004 rs=0.004 cgs=1p cgdmax=1p cgdmin=1p cjo=1p)
.model npm NPN(is=1e-14 bf=30 vaf=100 cje=30p cjc=10p tf=2n tr=3e-06)
.model ppm PNP(is=1e-14 bf=30 vaf=100 cje=30p cjc=10p tf=2n tr=3e-06)
.model body D(is=1n n=1.5 rs=0.01)
.model z15 D(is=1n n=1.5 bv=15 ibv=5m rs=10)
Vinput input 0 PWL(0 17 50u 17 51u 24)
Rsource input p01_vs 0.05
Cin p01_vs 0 10u
Venable p01_enable 0 PWL(0 2.7 70.3u 2.7 70.301u 0)
Cload vprot 0 0.00022
Rload vprot 0 1000000.0
Bload vprot 0 I=1.5*tanh(v(vprot)/0.2)
R17 p01_enable p01_on_base 4700
R18 p01_on_base 0 47000
R19 p01_enable p01_release_base 4700
R20 p01_release_base 0 47000
R21 p01_gate p01_on_col 101000
R22 p01_gate p01_vs 465300
R23 p01_off_base 0 2222
R24 p01_off_base p01_vs 100000
R25 p01_release_pbase p01_vs 47470
R26 p01_release_pbase p01_release_col 10000
R27 p01_off_col p01_gate 10.1
C5 p01_gate vprot 9.5e-09
C6 p01_gate p01_vs 1.05e-06
MQ1 Q1d p01_gate p01_vs pm
VQ1i Q1d vprot 0
DQ1body vprot p01_vs body
CQ1gs p01_gate p01_vs 3.21e-09
CQ1gd p01_gate vprot 2.9e-10
CQ1ds vprot p01_vs 600p
MQ2 Q2d p01_off_base p01_vs pm
VQ2i Q2d p01_off_col 0
DQ2body p01_off_col p01_vs body
CQ2gs p01_off_base p01_vs 2e-08
CQ2gd p01_off_base p01_off_col 6e-09
CQ2ds p01_off_col p01_vs 600p
Q3 p01_on_col p01_on_base 0 npm
Q4 p01_off_base p01_release_pbase p01_vs ppm
Q5 p01_release_col p01_release_base 0 npm
D4 p01_gate p01_vs z15
D9 p01_off_base p01_vs z15
.tran 5e-08 0.0003 0 5e-08
.end
